* Week 4, Lab C - I2C open-drain rising edge: pull-up Rp against bus capacitance Cb (a "virtual oscilloscope")
* Run:   ngspice -b ~/labs/week04/inertial_sensing/scripts/i2c_rise.cir | grep " ns "
* The driver (switch S1, 133 ohm on = the weakest legal driver: 0.4 V at 3 mA) holds SDA low until t = 2 us, then releases it; Rp charges Cb.
* Measures the 30-70 % rise time (the UM10204 definition) and V_OL for every (Rp, Cb) pair below, and prints
* the theory value 0.847 Rp Cb next to it. Expected at Rp = 2.2k, Cb = 100p: tr = 186 ns.
.param rp=2.2k cb=100p
V1 vdd 0 3.3
Rp vdd sda {rp}
Cb sda 0 {cb}
Vg g 0 DC 1 PULSE(1 0 2u 1n 1n 10u 20u)
S1 sda 0 g 0 od
.model od sw vt=0.5 vh=0.1 ron=133 roff=1e9
.tran 1n 6u
.control
set noaskquit
echo "   Rp     Cb     tr (ngspice)   0.847 Rp Cb    V_OL      (fast mode: tr <= 300 ns , V_OL <= 0.4 V)"
foreach r 0.8k 1k 2.2k 4.7k
  foreach c 50p 100p 200p 400p
    alterparam rp=$r
    alterparam cb=$c
    reset
    run
    meas tran t30 WHEN v(sda)=0.99 RISE=1
    meas tran t70 WHEN v(sda)=2.31 RISE=1
    meas tran vol FIND v(sda) AT=1u
    let tr_ns = (t70 - t30) * 1e9
    let th_ns = 0.847 * @rp[resistance] * @cb[capacitance] * 1e9
    echo "  $r   $c   $&tr_ns ns   $&th_ns ns   $&vol V"
  end
end
.endc
.end
